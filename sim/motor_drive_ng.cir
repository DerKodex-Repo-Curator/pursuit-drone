PURSUIT-1 brushed motor drive stage - AO3400A low-side, 32kHz PWM
* Worst case: fully-loaded 8520 at 4.2V, Rm chosen so steady I ~ 2.75A
* (research-measured full-throttle current). Lm = coreless winding ~100uH.
V1 batt 0 4.2
Rbat batt vbat 0.05
C1 vbat 0 220u
Rc1 vbat cx 0.03
Vg drv 0 PULSE(0 3.3 5u 30n 30n 18.75u 31.25u)
Rg drv gate 100
Rpd gate 0 10k
M1 sw gate 0 0 AO3400 L=1u W=50000u
D1 sw vbat SS34
Rm vbat mm 1.45
Lm mm sw 100u
.model AO3400 NMOS(Level=1 Vto=1.05 Kp=120 Lambda=0.05 Rd=0.012 Rs=0.008
+ Cgso=9n Cgdo=0.7n Cbd=0.35n Is=8n)
.model SS34 D(Is=1e-5 Rs=0.03 N=1.3 Cjo=250p M=0.5 Eg=0.69 BV=40)
.tran 100n 1m 0 100n
.control
run
let imot = i(Lm)
meas tran isteady AVG imot FROM=0.8m TO=1m
meas tran ipk MAX imot
meas tran vsw_clamp MAX v(sw)
meas tran vsw_min MIN v(sw)
meas tran vbat_sag MIN v(vbat)
meas tran vgate_hi MAX v(gate)
let pfet = v(sw)*i(vg)
meas tran vsw_on AVG v(sw) FROM=0.85m TO=0.855m
print isteady ipk vsw_clamp vsw_min vbat_sag vgate_hi
.endc
.end
