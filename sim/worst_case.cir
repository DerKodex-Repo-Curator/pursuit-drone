PURSUIT-1 worst case: 4-motor full throttle + boot safety + stall
* Motor model: Rm 1.45 -> ~2.75A at 100% duty (research full-throttle figure)
* Four identical stages share one battery rail + one 220uF bulk cap.
.param DUTY_ON=31.2u
V1 batt 0 4.2
Rbat batt vbat 0.06
C1 vbat 0 220u
Rc1 cx 0 1e-3
* --- 100% duty on all four (worst continuous case) ---
Vg1 d1 0 PULSE(0 3.3 5u 30n 30n 31.2u 31.25u)
Vg2 d2 0 PULSE(0 3.3 5u 30n 30n 31.2u 31.25u)
Vg3 d3 0 PULSE(0 3.3 5u 30n 30n 31.2u 31.25u)
Vg4 d4 0 PULSE(0 3.3 5u 30n 30n 31.2u 31.25u)
Rg1 d1 g1 100
Rp1 g1 0 10k
M1 s1 g1 0 0 AO3400 L=1u W=50000u
D1 s1 vbat SS34
Rm1 vbat m1 1.45
L1 m1 s1 100u
Rg2 d2 g2 100
Rp2 g2 0 10k
M2 s2 g2 0 0 AO3400 L=1u W=50000u
D2 s2 vbat SS34
Rm2 vbat m2 1.45
L2 m2 s2 100u
Rg3 d3 g3 100
Rp3 g3 0 10k
M3 s3 g3 0 0 AO3400 L=1u W=50000u
D3 s3 vbat SS34
Rm3 vbat m3 1.45
L3 m3 s3 100u
Rg4 d4 g4 100
Rp4 g4 0 10k
M4 s4 g4 0 0 AO3400 L=1u W=50000u
D4 s4 vbat SS34
Rm4 vbat m4 1.45
L4 m4 s4 100u
* --- BOOT SAFETY: gate 5 driven by a Hi-Z source (ESP32 pin floating at
* --- reset) modelled as a 1meg leak to 3.3V; pulldown must hold it low.
Vhiz hiz 0 3.3
Rleak hiz g5 1e6
Rp5 g5 0 10k
M5 s5 g5 0 0 AO3400 L=1u W=50000u
D5 s5 vbat SS34
Rm5 vbat m5 1.45
L5 m5 s5 100u
.model AO3400 NMOS(Level=1 Vto=1.05 Kp=120 Lambda=0.05 Rd=0.012 Rs=0.008
+ Cgso=9n Cgdo=0.7n Cbd=0.35n Is=8n)
.model SS34 D(Is=1e-5 Rs=0.03 N=1.3 Cjo=250p M=0.5 Eg=0.69 BV=40)
.tran 100n 1.5m 0 100n
.control
run
let itot = i(L1)+i(L2)+i(L3)+i(L4)
let pfet1 = v(s1)*i(L1)
meas tran i_one AVG i(L1) FROM=1.2m TO=1.5m
meas tran i_total_pk MAX itot
meas tran i_total_avg AVG itot FROM=1.2m TO=1.5m
meas tran vbat_sag MIN v(vbat) FROM=0.2m TO=1.5m
meas tran vsw_clamp MAX v(s1)
meas tran pfet_avg AVG pfet1 FROM=1.2m TO=1.5m
meas tran boot_gate_v MAX v(g5)
meas tran boot_motor_i MAX i(L5)
print i_one i_total_pk i_total_avg vbat_sag vsw_clamp pfet_avg boot_gate_v boot_motor_i
.endc
.end
